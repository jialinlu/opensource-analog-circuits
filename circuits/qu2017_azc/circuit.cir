.title qu2017_azc
* Test OpAmp ACDC

***************************************
* Step 1: Replace circuit netlist and parameter here.
***************************************
.subckt qu2017_azc_pin_3 gnda vdda vinn vinp vout
xm7 net057 net055 VDDA VDDA sky130_fd_pr__pfet_01v8 l='MOSFET_6_3_L_AZC2_PMOS' w='MOSFET_6_3_W_AZC2_PMOS*1' m='MOSFET_6_3_M_AZC2_PMOS*2'
xm6 net055 net055 VDDA VDDA sky130_fd_pr__pfet_01v8 l='MOSFET_6_3_L_AZC2_PMOS' w='MOSFET_6_3_W_AZC2_PMOS*1' m='MOSFET_6_3_M_AZC2_PMOS'
xm3 net078 VB1 VDDA VDDA sky130_fd_pr__pfet_01v8 l='MOSFET_0_14_L_BIASCM_PMOS' w='MOSFET_0_14_W_BIASCM_PMOS*1' m='6*MOSFET_0_14_M_BIASCM_PMOS'
xm13 VOUT net050 VDDA VDDA sky130_fd_pr__pfet_01v8 l='MOSFET_13_1_L_gmf2_PMOS' w='MOSFET_13_1_W_gmf2_PMOS*1' m='MOSFET_13_1_M_gmf2_PMOS'
xm8 net049 VB1 VDDA VDDA sky130_fd_pr__pfet_01v8 l='MOSFET_0_14_L_BIASCM_PMOS' w='MOSFET_0_14_W_BIASCM_PMOS*1' m='MOSFET_0_14_M_BIASCM_PMOS*2'
xm11 net094 net050 VDDA VDDA sky130_fd_pr__pfet_01v8 l='MOSFET_11_1_L_gm2_PMOS' w='MOSFET_11_1_W_gm2_PMOS*1' m='MOSFET_11_1_M_gm2_PMOS'
xm5 net050 VOUTN VDDA VDDA sky130_fd_pr__pfet_01v8 l='MOSFET_0_14_L_BIASCM_PMOS' w='MOSFET_0_14_W_BIASCM_PMOS*1' m='MOSFET_0_14_M_BIASCM_PMOS'
xm4 VOUTN VOUTN VDDA VDDA sky130_fd_pr__pfet_01v8 l='MOSFET_0_14_L_BIASCM_PMOS' w='MOSFET_0_14_W_BIASCM_PMOS*1' m='MOSFET_0_14_M_BIASCM_PMOS'
xm10 net063 VINP net019 net019 sky130_fd_pr__pfet_01v8 l='MOSFET_9_2_L_gm1_PMOS' w='MOSFET_9_2_W_gm1_PMOS*1' m='MOSFET_9_2_M_gm1_PMOS'
xm9 DM_2 VINN net019 net019 sky130_fd_pr__pfet_01v8 l='MOSFET_9_2_L_gm1_PMOS' w='MOSFET_9_2_W_gm1_PMOS*1' m='MOSFET_9_2_M_gm1_PMOS'
xm2 net019 VB1 VDDA VDDA sky130_fd_pr__pfet_01v8 l='MOSFET_0_14_L_BIASCM_PMOS' w='MOSFET_0_14_W_BIASCM_PMOS*1' m='MOSFET_0_14_M_BIASCM_PMOS*2'
xm1 VB4 VB1 VDDA VDDA sky130_fd_pr__pfet_01v8 l='MOSFET_0_14_L_BIASCM_PMOS' w='MOSFET_0_14_W_BIASCM_PMOS*1' m='MOSFET_0_14_M_BIASCM_PMOS'
xm0 VB1 VB1 VDDA VDDA sky130_fd_pr__pfet_01v8 l='MOSFET_0_14_L_BIASCM_PMOS' w='MOSFET_0_14_W_BIASCM_PMOS*1' m='MOSFET_0_14_M_BIASCM_PMOS'
xm24 net049 net057 GNDA GNDA sky130_fd_pr__nfet_01v8 l='MOSFET_24_8_L_AZC3_NMOS' w='MOSFET_24_8_W_AZC3_NMOS*1' m='MOSFET_24_8_M_AZC3_NMOS'
xm12 net055 net094 GNDA GNDA sky130_fd_pr__nfet_01v8 l='MOSFET_12_1_L_AZC1_NMOS' w='MOSFET_12_1_W_AZC1_NMOS*1' m='MOSFET_12_1_M_AZC1_NMOS'
xm16 net077 DM_2 GNDA GNDA sky130_fd_pr__nfet_01v8 l='MOSFET_14_4_L_LOAD1_NMOS' w='MOSFET_14_4_W_LOAD1_NMOS*1' m='MOSFET_14_4_M_LOAD1_NMOS'
xm17 net082 net063 GNDA GNDA sky130_fd_pr__nfet_01v8 l='MOSFET_14_4_L_LOAD1_NMOS' w='MOSFET_14_4_W_LOAD1_NMOS*1' m='MOSFET_14_4_M_LOAD1_NMOS'
xm18 VOUT net049 GNDA GNDA sky130_fd_pr__nfet_01v8 l='MOSFET_18_1_L_gm3_NMOS' w='MOSFET_18_1_W_gm3_NMOS*1' m='MOSFET_18_1_M_gm3_NMOS'
xm22 net094 net051 GNDA GNDA sky130_fd_pr__nfet_01v8 l='MOSFET_24_8_L_AZC3_NMOS' w='MOSFET_24_8_W_AZC3_NMOS*1' m='MOSFET_24_8_M_AZC3_NMOS*4'
xm23 net057 net043 GNDA GNDA sky130_fd_pr__nfet_01v8 l='MOSFET_24_8_L_AZC3_NMOS' w='MOSFET_24_8_W_AZC3_NMOS*1' m='MOSFET_24_8_M_AZC3_NMOS*3'
xm20 DM_2 VB4 GNDA GNDA sky130_fd_pr__nfet_01v8 l='MOSFET_19_16_L_BIASCM_NMOS' w='MOSFET_19_16_W_BIASCM_NMOS*7' m='MOSFET_19_16_M_BIASCM_NMOS'
xm14 VOUTN net077 DM_2 GNDA sky130_fd_pr__nfet_01v8 l='MOSFET_14_4_L_LOAD1_NMOS' w='MOSFET_14_4_W_LOAD1_NMOS*1' m='MOSFET_14_4_M_LOAD1_NMOS'
xm21 net063 VB4 GNDA GNDA sky130_fd_pr__nfet_01v8 l='MOSFET_19_16_L_BIASCM_NMOS' w='MOSFET_19_16_W_BIASCM_NMOS*7' m='MOSFET_19_16_M_BIASCM_NMOS'
xm15 net050 net082 net063 GNDA sky130_fd_pr__nfet_01v8 l='MOSFET_14_4_L_LOAD1_NMOS' w='MOSFET_14_4_W_LOAD1_NMOS*1' m='MOSFET_14_4_M_LOAD1_NMOS'
xm19 VB4 VB4 GNDA GNDA sky130_fd_pr__nfet_01v8 l='MOSFET_19_16_L_BIASCM_NMOS' w='MOSFET_19_16_W_BIASCM_NMOS*2' m='MOSFET_19_16_M_BIASCM_NMOS'
I0 VB1 GNDA 'CURRENT_0_BIAS'
C2 net043 GNDA 'CAPACITOR_2'
C1 net051 GNDA 'CAPACITOR_1'
C0 net063 VOUT 'CAPACITOR_0'
R3 net057 net043 'RESISTOR_3'
R2 net057 net051 'RESISTOR_2'
R1 net078 net082 'RESISTOR_1'
R0 net078 net077 'RESISTOR_0'
.ends Qu2017_AZC_Pin_3

.PARAM
+ CAPACITOR_0=810f CAPACITOR_1=404f CAPACITOR_2=310f
+ MOSFET_0_14_L_BIASCM_PMOS=1 MOSFET_0_14_M_BIASCM_PMOS=4
+ MOSFET_0_14_W_BIASCM_PMOS=1 MOSFET_11_1_L_gm2_PMOS=1
+ MOSFET_11_1_M_gm2_PMOS=4 MOSFET_11_1_W_gm2_PMOS=1
+ MOSFET_12_1_L_AZC1_NMOS=1 MOSFET_12_1_M_AZC1_NMOS=4
+ MOSFET_12_1_W_AZC1_NMOS=1 MOSFET_13_1_L_gmf2_PMOS=1
+ MOSFET_13_1_M_gmf2_PMOS=4 MOSFET_13_1_W_gmf2_PMOS=1
+ MOSFET_14_4_L_LOAD1_NMOS=1 MOSFET_14_4_M_LOAD1_NMOS=4
+ MOSFET_14_4_W_LOAD1_NMOS=1 MOSFET_18_1_L_gm3_NMOS=1
+ MOSFET_18_1_M_gm3_NMOS=4 MOSFET_18_1_W_gm3_NMOS=1
+ MOSFET_19_16_L_BIASCM_NMOS=1 MOSFET_19_16_M_BIASCM_NMOS=4
+ MOSFET_19_16_W_BIASCM_NMOS=1 MOSFET_24_8_L_AZC3_NMOS=1
+ MOSFET_24_8_M_AZC3_NMOS=4 MOSFET_24_8_W_AZC3_NMOS=1
+ MOSFET_6_3_L_AZC2_PMOS=1 MOSFET_6_3_M_AZC2_PMOS=4
+ MOSFET_6_3_W_AZC2_PMOS=1 MOSFET_9_2_L_gm1_PMOS=1
+ MOSFET_9_2_M_gm1_PMOS=4 MOSFET_9_2_W_gm1_PMOS=1 RESISTOR_0=35K
+ RESISTOR_1=35k RESISTOR_2=350k RESISTOR_3=40k CURRENT_0_BIAS=1u
+ CLOAD=1500p VCM=300m

.param mc_mm_switch=0
.param mc_pr_switch=0

.lib "../../sky130_pdk/libs.tech/ngspice/sky130.lib.spice" tt
*.include ../mosfet_model/sky130_pdk/libs.tech/ngspice/r+c/res_typical__cap_typical.spice
*.include ../mosfet_model/sky130_pdk/libs.tech/ngspice/r+c/res_typical__cap_typical__lin.spice
*.include ../mosfet_model/sky130_pdk/libs.tech/ngspice/corners/tt/specialized_cells.spice

.PARAM supply_voltage = 1.8
.PARAM VCM_ratio = 0.25
.PARAM PARAM_CLOAD =500.00p

V1 vdd 0 'supply_voltage'
V2 vss 0 0

Vindc opin 0 'supply_voltage*VCM_ratio'
Vin signal_in 0 dc 'supply_voltage*VCM_ratio' ac 1 sin('supply_voltage*VCM_ratio' 100m 500)

Lfb opout opout_dc 1T
Cin opout_dc signal_in 1T

* XOP gnda vdda vinn vinp vout
*        |  |     |     |   |
*        |  |     |     |   Output
*        |  |     |     Non-inverting Input
*        |  |      Inverting Input
*        |  Positive Supply
*        Negative Supply

***************************************
* Step 3: Replace circuit name below.
* e.g. Leung_NMCNR_Pin_3 -> Leung_NMCF_Pin_3
***************************************
*    ADM TB
Xop1 vss vdd opout_dc opin opout  Qu2017_AZC_Pin_3
Cload1 opout 0 'PARAM_CLOAD'

*   ACM TB
xop2 vss vdd cm2 cm1 cm3  Qu2017_AZC_Pin_3
Cload2 cm3 0 'PARAM_CLOAD'
vcmdc cm0 0 'supply_voltage*VCM_ratio'
vcmac1 cm1 cm0 0 ac=1
vcmac2 cm2 cm3 0 ac=1
.meas ac cmrrdc find vdb(cm3) at = 0.1
.meas ac dcgain find vdb(opout) at = 0.1
.meas ac gain_bandwidth_product when vdb(opout)=0
.meas ac phase_in_rad find vp(opout) when vdb(opout)=0
.meas ac phase_in_deg param='phase_in_rad*180/3.1416'

* PSRR   TB
VGNDApsrr gndpsrr 0 0 AC=1
VVDDApsrr vddpsrr 0 'supply_voltage'  AC=1
xop3 vss vddpsrr ppsr1 opin ppsr1  Qu2017_AZC_Pin_3
Cload3 ppsr1 0 'PARAM_CLOAD'
xop4 gndpsrr vdd npsr1 opin npsr1  Qu2017_AZC_Pin_3
Cload4 npsr1 0 'PARAM_CLOAD'
.measure ac DCPSRp find vdb(ppsr1) at = 0.1
.measure ac DCPSRn find vdb(npsr1) at = 0.1

* DC ALL  TB
VVDDdc VDDdc 0 'supply_voltage'
xop5 vss vdddc vout6 opin vout6  Qu2017_AZC_Pin_3
Cload5 vout6 0 'PARAM_CLOAD'
* TC meas
.measure dc maxval MAX V(vout6) from=-40 to=125
.measure dc minval MIN V(vout6) from=-40 to=125
.measure dc avgval AVG V(vout6) from=-40 to=125
.measure dc ppavl  PP V(vout6) from=-40 to=125
.measure dc TC param='ppavl/avgval/165'
* Power meas
.meas dc Ivdd25 FIND I(VVDDDC) AT=25
.meas dc Power param='-1*Ivdd25*supply_voltage'
*   Vos.meas
.meas dc vout25 FIND V(vout6) AT=25
.meas dc vos25 param = 'vout25-supply_voltage*VCM_ratio'

.control

DC temp -40 125 0.1
plot v(vout6)

ac dec 10 0.1 1G
plot vdb(opout) vdb(cm3) vdb(ppsr1) vdb(npsr1)
plot vp(opout)

.endc

.end
