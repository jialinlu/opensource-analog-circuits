* Charge Pump Circuit - Parametric Sizing

VDD 1 0 DC 1.20
Vclock1 7 0 DC 0 PULSE(0.00 5.00 1.00N 0.10N 0.10N 1.00N 2.20N)
V14 14 0 DC 1.80V

* Parameters
.param WN1=0.30u
.param WN8=0.50u
.param WP1=0.30u
.param WP5=0.50u
.param LCHN=0.10u
.param LCHP=0.10u
.param C_CAP=10p

* Switch Transistors
MN1 7 16 9 0 N1  W=WN1 L=LCHN
MN2 7 17 8 0 N1  W=WN1 L=LCHN
MN3 7 7 13 0 N1  W=WN1 L=LCHN
MN4 7 18 10 0 N1  W=WN1 L=LCHN
MN5 14 14 7 0 N1  W=WN1 L=LCHN
MN6 14 11 7 0 N1  W=WN1 L=LCHN
MN7 14 19 11 0 N1  W=WN1 L=LCHN
MN8 0 7 7 0 N1  W=WN8 L=LCHN
MP1 8 17 7 1 P1  W=WP1 L=LCHP
MP2 9 16 7 1 P1  W=WP1 L=LCHP
MP3 10 18 7 1 P1  W=WP1 L=LCHP
MP4 11 19 7 1 P1  W=WP1 L=LCHP
MP5 1 7 7 1 P1  W=WP5 L=LCHP

* Charge-transfer capacitors
C1 13 0 {C_CAP}
C2 7 0 {C_CAP}
C3 7 0 {C_CAP}
C4 7 0 {C_CAP}
C5 7 0 {C_CAP}
C6 7 0 {C_CAP}

* n-MOS low leakage
.MODEL N1 NMOS LEVEL=14 VTHO=0.28 U0=0.060 TOXE= 1.2E-9 LINT=0.015U
+K1 =0.450 K2=0.100 DVT0=2.300
+DVT1=0.570 LPE0=23.000e-9 ETA0=0.080
+NFACTOR=  0.9 U0=0.060 UA=3.400e-15
+WINT=0.005U LPE0=23.000e-9
+KT1=-0.060 UTE=-1.800 VOFF=0.010
+XJ=0.150U NDEP=170.000e15 PCLM=1.100
+CGSO=100.0p CGDO=100.0p
+CGBO= 60.0p

* p-MOS low leakage
.MODEL P1 PMOS LEVEL=14 VTHO=-0.32 U0=0.027 TOXE= 1.2E-9 LINT=0.015U
+K1 =0.450 K2=0.100 DVT0=2.300
+DVT1=0.570 LPE0=23.000e-9 ETA0=0.080
+NFACTOR=  1.9 U0=0.027 UA=2.200e-15
+WINT=0.005U LPE0=23.000e-9
+KT1=-0.060 UTE=-1.800 VOFF=0.010
+XJ=0.150U NDEP=170.000e15 PCLM=0.700
+CGSO=100.0p CGDO=100.0p
+CGBO= 60.0p

* Transient analysis (batch mode)
.tran 0.1N 50N
.print tran V(13) V(7) V(14)
.meas tran vout FIND V(13) AT=50N

.END
