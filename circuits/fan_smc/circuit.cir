.title fan_smc
* Test OpAmp ACDC (Fan_SMC_Pin_3)

.subckt fan_smc_pin_3 gnda vdda vinn vinp vout
xm11 VOUT net050 VDDA VDDA sky130_fd_pr__pfet_01v8 l='MOSFET_11_1_L_gmf2_PMOS' w='MOSFET_11_1_W_gmf2_PMOS*1' m='MOSFET_11_1_M_gmf2_PMOS'
xm7 net049 net013 VDDA VDDA sky130_fd_pr__pfet_01v8 l='MOSFET_0_8_L_BIASCM_PMOS' w='MOSFET_0_8_W_BIASCM_PMOS*1' m='MOSFET_0_8_M_BIASCM_PMOS'
xm10 net043 net050 VDDA VDDA sky130_fd_pr__pfet_01v8 l='MOSFET_10_1_L_gm2_PMOS' w='MOSFET_10_1_W_gm2_PMOS*1' m='MOSFET_10_1_M_gm2_PMOS'
xm6 net050 VOUTN VDDA VDDA sky130_fd_pr__pfet_01v8 l='MOSFET_0_8_L_BIASCM_PMOS' w='MOSFET_0_8_W_BIASCM_PMOS*1' m='MOSFET_0_8_M_BIASCM_PMOS'
xm5 VOUTN VOUTN VDDA VDDA sky130_fd_pr__pfet_01v8 l='MOSFET_0_8_L_BIASCM_PMOS' w='MOSFET_0_8_W_BIASCM_PMOS*1' m='MOSFET_0_8_M_BIASCM_PMOS'
xm9 net063 VINP net31 net31 sky130_fd_pr__pfet_01v8 l='MOSFET_8_2_L_gm1_PMOS' w='MOSFET_8_2_W_gm1_PMOS*1' m='MOSFET_8_2_M_gm1_PMOS'
xm8 DM_2 VINN net31 net31 sky130_fd_pr__pfet_01v8 l='MOSFET_8_2_L_gm1_PMOS' w='MOSFET_8_2_W_gm1_PMOS*1' m='MOSFET_8_2_M_gm1_PMOS'
xm4 net31 net013 VDDA VDDA sky130_fd_pr__pfet_01v8 l='MOSFET_0_8_L_BIASCM_PMOS' w='MOSFET_0_8_W_BIASCM_PMOS*1' m='4*MOSFET_0_8_M_BIASCM_PMOS'
xm3 VB3 net013 VDDA VDDA sky130_fd_pr__pfet_01v8 l='MOSFET_0_8_L_BIASCM_PMOS' w='MOSFET_0_8_W_BIASCM_PMOS*1' m='MOSFET_0_8_M_BIASCM_PMOS'
xm2 DM_1 net013 VDDA VDDA sky130_fd_pr__pfet_01v8 l='MOSFET_0_8_L_BIASCM_PMOS' w='MOSFET_0_8_W_BIASCM_PMOS*1' m='MOSFET_0_8_M_BIASCM_PMOS'
xm1 VB4 net013 VDDA VDDA sky130_fd_pr__pfet_01v8 l='MOSFET_0_8_L_BIASCM_PMOS' w='MOSFET_0_8_W_BIASCM_PMOS*1' m='MOSFET_0_8_M_BIASCM_PMOS'
xm0 net013 net013 VDDA VDDA sky130_fd_pr__pfet_01v8 l='MOSFET_0_8_L_BIASCM_PMOS' w='MOSFET_0_8_W_BIASCM_PMOS*1' m='MOSFET_0_8_M_BIASCM_PMOS'
xm23 VOUT net049 GNDA GNDA sky130_fd_pr__nfet_01v8 l='MOSFET_23_1_L_gm3_NMOS' w='MOSFET_23_1_W_gm3_NMOS*1' m='MOSFET_23_1_M_gm3_NMOS'
xm22 net049 net043 GNDA GNDA sky130_fd_pr__nfet_01v8 l='MOSFET_21_2_L_LOAD2_NMOS' w='MOSFET_21_2_W_LOAD2_NMOS*1' m='MOSFET_21_2_M_LOAD2_NMOS'
xm21 net043 net043 GNDA GNDA sky130_fd_pr__nfet_01v8 l='MOSFET_21_2_L_LOAD2_NMOS' w='MOSFET_21_2_W_LOAD2_NMOS*1' m='MOSFET_21_2_M_LOAD2_NMOS'
xm19 DM_2 VB4 GNDA GNDA sky130_fd_pr__nfet_01v8 l='MOSFET_17_7_L_BIASCM_NMOS' w='MOSFET_17_7_W_BIASCM_NMOS*1' m='MOSFET_17_7_M_BIASCM_NMOS*8'
xm15 VOUTN VB3 DM_2 GNDA sky130_fd_pr__nfet_01v8 l='MOSFET_17_7_L_BIASCM_NMOS' w='MOSFET_17_7_W_BIASCM_NMOS*1' m='MOSFET_17_7_M_BIASCM_NMOS*4'
xm20 net063 VB4 GNDA GNDA sky130_fd_pr__nfet_01v8 l='MOSFET_17_7_L_BIASCM_NMOS' w='MOSFET_17_7_W_BIASCM_NMOS*1' m='MOSFET_17_7_M_BIASCM_NMOS*8'
xm16 net050 VB3 net063 GNDA sky130_fd_pr__nfet_01v8 l='MOSFET_17_7_L_BIASCM_NMOS' w='MOSFET_17_7_W_BIASCM_NMOS*1' m='MOSFET_17_7_M_BIASCM_NMOS*4'
xm17 net54 VB4 GNDA GNDA sky130_fd_pr__nfet_01v8 l='MOSFET_17_7_L_BIASCM_NMOS' w='MOSFET_17_7_W_BIASCM_NMOS*1' m='MOSFET_17_7_M_BIASCM_NMOS*4'
xm14 VB3 VB3 GNDA GNDA sky130_fd_pr__nfet_01v8 l='MOSFET_17_7_L_BIASCM_NMOS' w='MOSFET_17_7_W_BIASCM_NMOS*1' m='MOSFET_17_7_M_BIASCM_NMOS'
xm12 VB4 VB3 net54 GNDA sky130_fd_pr__nfet_01v8 l='MOSFET_17_7_L_BIASCM_NMOS' w='MOSFET_17_7_W_BIASCM_NMOS*1' m='MOSFET_17_7_M_BIASCM_NMOS*4'
xm18 net56 VB4 GNDA GNDA sky130_fd_pr__nfet_01v8 l='MOSFET_17_7_L_BIASCM_NMOS' w='MOSFET_17_7_W_BIASCM_NMOS*1' m='MOSFET_17_7_M_BIASCM_NMOS*4'
xm13 DM_1 VB3 net56 GNDA sky130_fd_pr__nfet_01v8 l='MOSFET_17_7_L_BIASCM_NMOS' w='MOSFET_17_7_W_BIASCM_NMOS*1' m='MOSFET_17_7_M_BIASCM_NMOS*4'
I0 net013 GNDA 'CURRENT_0_BIAS'
C0 net050 VOUT 'CAPACITOR_0'
.ends Fan_SMC_Pin_3

.PARAM
+ MOSFET_10_1_L_gm2_PMOS=1 MOSFET_10_1_M_gm2_PMOS=8
+ MOSFET_10_1_W_gm2_PMOS=1 MOSFET_11_1_L_gmf2_PMOS=1
+ MOSFET_11_1_M_gmf2_PMOS=32 MOSFET_11_1_W_gmf2_PMOS=1
+ MOSFET_23_1_L_gm3_NMOS=1 MOSFET_23_1_M_gm3_NMOS=16
+ MOSFET_23_1_W_gm3_NMOS=1 MOSFET_8_2_L_gm1_PMOS=1
+ MOSFET_8_2_M_gm1_PMOS=4 MOSFET_8_2_W_gm1_PMOS=1
+ MOSFET_0_8_L_BIASCM_PMOS=1 MOSFET_0_8_M_BIASCM_PMOS=16
+ MOSFET_0_8_W_BIASCM_PMOS=1 MOSFET_17_7_L_BIASCM_NMOS=1
+ MOSFET_17_7_M_BIASCM_NMOS=4 MOSFET_17_7_W_BIASCM_NMOS=1
+ MOSFET_21_2_L_LOAD2_NMOS=1 MOSFET_21_2_M_LOAD2_NMOS=4
+ MOSFET_21_2_W_LOAD2_NMOS=1 CAPACITOR_0=5p CURRENT_0_BIAS=60u
+ CLOAD=10p VCM=300m

.param mc_mm_switch=0
.param mc_pr_switch=0

.lib "../../sky130_pdk/libs.tech/ngspice/sky130.lib.spice" tt

.PARAM supply_voltage = 1.8
.PARAM VCM_ratio = 0.25
.PARAM PARAM_CLOAD =500.00p

V1 vdd 0 'supply_voltage'
V2 vss 0 0

Vindc opin 0 'supply_voltage*VCM_ratio'
Vin signal_in 0 dc 'supply_voltage*VCM_ratio' ac 1 sin('supply_voltage*VCM_ratio' 100m 500)

Lfb opout opout_dc 1T
Cin opout_dc signal_in 1T

*    ADM TB
Xop1 vss vdd opout_dc opin opout  Fan_SMC_Pin_3
Cload1 opout 0 'PARAM_CLOAD'

*   ACM TB
xop2 vss vdd cm2 cm1 cm3  Fan_SMC_Pin_3
Cload2 cm3 0 'PARAM_CLOAD'
vcmdc cm0 0 'supply_voltage*VCM_ratio'
vcmac1 cm1 cm0 0 ac=1
vcmac2 cm2 cm3 0 ac=1

* PSRR   TB
VGNDApsrr gndpsrr 0 0 AC=1
VVDDApsrr vddpsrr 0 'supply_voltage'  AC=1
xop3 vss vddpsrr ppsr1 opin ppsr1  Fan_SMC_Pin_3
Cload3 ppsr1 0 'PARAM_CLOAD'
xop4 gndpsrr vdd npsr1 opin npsr1  Fan_SMC_Pin_3
Cload4 npsr1 0 'PARAM_CLOAD'

* DC ALL  TB
VVDDdc VDDdc 0 'supply_voltage'
xop5 vss vdddc vout6 opin vout6  Fan_SMC_Pin_3
Cload5 vout6 0 'PARAM_CLOAD'

.control
save all
set filetype=ascii
set units=degrees

DC temp -40 125 0.1
meas dc maxval MAX V(vout6) from=-40 to=125
meas dc minval MIN V(vout6) from=-40 to=125
meas dc avgval AVG V(vout6) from=-40 to=125
meas dc ppavl  PP V(vout6) from=-40 to=125
meas dc Ivdd25 FIND I(VVDDDC) AT=25
meas dc vout25 FIND V(vout6) AT=25
wrdata AMP_TB_ACDC_DC_raw ppavl avgval Ivdd25 vout25

ac dec 10 0.1 1G
meas ac cmrrdc find vdb(cm3) at = 0.1
meas ac dcgain find vdb(opout) at = 0.1
meas ac gain_bandwidth_product when vdb(opout)=0
meas ac phase_margin find vp(opout) when vdb(opout)=0
meas ac DCPSRp find vdb(ppsr1) at = 0.1
meas ac DCPSRn find vdb(npsr1) at = 0.1
wrdata AMP_TB_ACDC_CMRR_dcgain cmrrdc dcgain
wrdata AMP_TB_ACDC_GBW_PM gain_bandwidth_product phase_margin
wrdata AMP_TB_ACDC_PSRR DCPSRp DCPSRn

.endc

.end
